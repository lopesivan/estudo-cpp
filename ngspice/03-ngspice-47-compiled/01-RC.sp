* Circuito RC com fonte senoidal

V1 in 0 SIN(0 10 1k)
R1 in out 1k
C1 out 0 1u

.tran 10u 10m

.end
